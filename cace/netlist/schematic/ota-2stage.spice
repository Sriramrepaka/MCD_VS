** sch_path: /home/sriram/MCD_VS/xschem/ota-2stage.sch
.subckt ota-2stage vdd ibias vinn vout vinp vss
*.PININFO vdd:B vss:B ibias:I vout:B vinn:I vinp:I
XM1 net1 vinn net3 net3 sg13_lv_nmos w=2.5u l=2u ng=1 m=1 mm_ok=1
XM2 net2 vinp net3 net3 sg13_lv_nmos w=2.5u l=2u ng=1 m=1 mm_ok=1
XM4 net2 net1 vdd vdd sg13_lv_pmos w=3.5u l=2u ng=1 m=1 mm_ok=1
XM3 net1 net1 vdd vdd sg13_lv_pmos w=3.5u l=2u ng=1 m=1 mm_ok=1
XM5 vout net2 vdd vdd sg13_lv_pmos w=9.5u l=2u ng=1 m=1 mm_ok=1
XM6 ibias ibias vss vss sg13_lv_nmos w=2u l=2u ng=1 m=1 mm_ok=1
XM7 net3 ibias vss vss sg13_lv_nmos w=1.5u l=2u ng=1 m=1 mm_ok=1
XM8 vout ibias vss vss sg13_lv_nmos w=1u l=2u ng=1 m=1 mm_ok=1
XCM vout net4 cap_cmim w=25e-6 l=25e-6 m=1 mm_ok=1
XRN net2 net4 GND rhigh w=1e-6 l=19.5e-6 m=1 b=0 mm_ok=1
.ends
