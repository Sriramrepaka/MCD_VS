** sch_path: /home/sriram/MCD_VS/_runs/RUN_2026-06-30_16-33-54/parameters/noise_params/run_3268/ota-2stage-noise.sch
**.subckt ota-2stage-noise
Vdd v_dd GND 1.45
Vss v_ss GND 0
C1 v_out v_ss 1e-12 m=1
Vin v_in v_ss dc 0.7 ac 1
I0 v_dd net1 1.9999999999999998e-05
.save v(v_in)
.save v(v_out)
x1 v_dd net1 v_out v_out v_in v_ss ota-2stage
**** begin user architecture code

.include /home/sriram/MCD_VS/cace/netlist/schematic/ota-2stage.spice
.temp 27
.param mc_ok = 1
.option SEED=12345
.option sparse

.control
set num_threads=1
save all
noise v(v_out) Vin dec 101 1k 100MEG

let noise=onoise_total
echo $&noise > /home/sriram/MCD_VS/_runs/RUN_2026-06-30_16-33-54/parameters/noise_params/run_3268/ota-2stage-noise_3268.data
.endc

.lib cornerMOSlv.lib mos_sf
.lib cornerMOShv.lib mos_sf
.lib cornerRES.lib res_typ
.lib cornerCAP.lib cap_typ

**** end user architecture code
**.ends
.GLOBAL GND
.end
