** sch_path: /foss/designs/MCD_VS/Testbench/untitled-2.sch
**.subckt untitled-2 vdd vdd vdd vss vss vdd vdd vss vdd vdd vss vdd vdd vss
*.iopin vdd
*.iopin vdd
*.iopin vdd
*.iopin vss
*.iopin vss
*.iopin vdd
*.iopin vdd
*.iopin vss
*.iopin vdd
*.iopin vdd
*.iopin vss
*.iopin vdd
*.iopin vdd
*.iopin vss
I0 vdd net1 20u
Vdd vdd GND 1.5
Vss vss GND 0
v_in_p v_in GND dc 0.8 ac 1
x1 vdd net1 net3 net3 net4 vss ota-2stage
R1 net3 net2 18.7MEG
R2 net5 net4 37.4MEG
C1 net2 v_in 0.6p
C2 net4 net2 0.6p
V1 net5 GND dc 0.8
I1 vdd net6 20u
R3 v_in net7 37.5MEG
R4 net7 net8 37.5MEG
C3 net8 GND 0.3p
C4 net7 net9 0.6p
x2 vdd net6 net9 net9 net8 vss ota-2stage
I2 vdd net10 20u
R5 net9 net11 37.5MEG
R6 net11 net12 37.5MEG
C5 net12 GND 0.3p
C6 net11 v_lpf 0.6p
x3 vdd net10 v_lpf v_lpf net12 vss ota-2stage
I3 vdd net13 20u
x4 vdd net13 v_hpf v_hpf net15 vss ota-2stage
R7 v_hpf net14 18.7MEG
R8 net16 net15 37.4MEG
C7 net14 net3 0.6p
C8 net15 net14 0.6p
V2 net16 GND dc 0.8
**** begin user architecture code

.temp 27
.control
option sparse
save all

* Sweep from 100 Hz to 1 MHz
ac dec 101 100 1MEG

* Plot the response to see your beautiful 10kHz cutoff!
plot v(v_lpf) v(v_hpf)
plot 20*log10(v(v_lpf)) 20*log10(v(v_hpf))

* Calculate the exact -3dB cutoff frequency
meas ac dcgain MAX vmag(v_out) FROM=50k TO=0.5MEG
let f3db_target = dcgain / sqrt(2)
meas ac fbw WHEN vmag(v_out)=f3db_target RISE=1

print dcgain
print fbw
.endc

 .lib cornerMOSlv.lib mos_tt
.lib cornerCAP.lib cap_typ
.lib cornerRES.lib res_typ

**** end user architecture code
**.ends

* expanding   symbol:  ota-2stage.sym # of pins=6
** sym_path: /foss/designs/MCD_VS/Testbench/ota-2stage.sym
** sch_path: /foss/designs/MCD_VS/Testbench/ota-2stage.sch
.subckt ota-2stage vdd ibias vinn vout vinp vss
*.iopin vdd
*.iopin vss
*.ipin ibias
*.iopin vout
*.ipin vinn
*.ipin vinp
XM1 net1 vinn net3 net3 sg13_lv_nmos w=1u l=2u ng=1
XM2 net2 vinp net3 net3 sg13_lv_nmos w=1u l=2u ng=1
XM4 net2 net1 vdd vdd sg13_lv_pmos w=1u l=2u ng=1
XM3 net1 net1 vdd vdd sg13_lv_pmos w=1u l=2u ng=1
XM5 vout net2 vdd vdd sg13_lv_pmos w=9.5u l=2u ng=1
XM6 ibias ibias vss vss sg13_lv_nmos w=2u l=2u ng=1
XM7 net3 ibias vss vss sg13_lv_nmos w=0.5u l=2u ng=1
XM8 vout ibias vss vss sg13_lv_nmos w=1u l=2u ng=1
XCM vout net4 cap_cmim w=20e-6 l=20e-6
XRN net2 net4 GND rhigh w=1e-6 l=12.6e-6 m=1 b=0
.ends

.GLOBAL GND
.end
