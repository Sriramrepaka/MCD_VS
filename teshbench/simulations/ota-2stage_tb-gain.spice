** sch_path: /foss/designs/MCD_VS/Testbench/ota-2stage_tb-gain.sch
**.subckt ota-2stage_tb-gain vss vdd vdd vdd vss
*.iopin vss
*.iopin vdd
*.iopin vdd
*.iopin vdd
*.iopin vss
x1 vdd net1 net2 v_out v_in vss ota-2stage
Vdd vdd GND 1.5
Vss vss GND 0
I0 vdd net1 20u
v_in_p v_in 0 dc 0.7 ac 1
C_out v_out GND 100f
L5 net2 v_out 1T
C1 net2 GND 1T
**** begin user architecture code

.control

* Run the AC sweep from 1 Hz to 1 GHz
  ac dec 100 1 1G

  * Measure the exact Open-Loop DC gain at 1 Hz
  meas ac dc_gain_dB max vdb(v_out)

  * Measure the true Unity-Gain Bandwidth (where it crosses 0 dB)
  meas ac true_ugbw when vdb(v_out)=0

  * Plot the magnitude (Gain) and phase
  plot vdb(v_out)
  plot cph(v_out)*(180/pi)
.endc

 .lib cornerMOSlv.lib mos_tt
.lib cornerCAP.lib cap_typ
.lib cornerRES.lib res_typ

**** end user architecture code
**.ends

* expanding   symbol:  ota-2stage.sym # of pins=6
** sym_path: /foss/designs/MCD_VS/Testbench/ota-2stage.sym
** sch_path: /foss/designs/MCD_VS/Testbench/ota-2stage.sch
.subckt ota-2stage vdd ibias vinn vout vinp vss
*.iopin vdd
*.iopin vss
*.ipin ibias
*.iopin vout
*.ipin vinn
*.ipin vinp
XM1 net1 vinn net3 net3 sg13_lv_nmos w=1u l=2u ng=1
XM2 net2 vinp net3 net3 sg13_lv_nmos w=1u l=2u ng=1
XM4 net2 net1 vdd vdd sg13_lv_pmos w=1u l=2u ng=1
XM3 net1 net1 vdd vdd sg13_lv_pmos w=1u l=2u ng=1
XM5 vout net2 vdd vdd sg13_lv_pmos w=9.5u l=2u ng=1
XM6 ibias ibias vss vss sg13_lv_nmos w=2u l=2u ng=1
XM7 net3 ibias vss vss sg13_lv_nmos w=0.5u l=2u ng=1
XM8 vout ibias vss vss sg13_lv_nmos w=1u l=2u ng=1
XCM vout net4 cap_cmim w=19.5e-6 l=19.5e-6
XRN net2 net4 GND rhigh w=1e-6 l=12.6e-6 m=1 b=0
.ends

.GLOBAL GND
.end
