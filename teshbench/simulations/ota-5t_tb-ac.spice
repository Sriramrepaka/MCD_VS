** sch_path: /foss/designs/MCD/analog-circuit-design/xschem/ota-5t_tb-ac.sch
**.subckt ota-5t_tb-ac
Vdd v_dd GND 1.5
xota v_dd v_out v_in v_out net1 v_ena v_ss ota-5t
Vss v_ss GND 0
C1 v_out v_ss 50f
Vin v_in v_ss dc 0.8 ac 1
I0 v_dd net1 20u
Venable v_ena v_ss 1.5
.save v(v_in)
.save v(v_out)
.save v(v_ena)
I1 v_ss v_out dc 0 ac 0
**** begin user architecture code
 .lib cornerMOSlv.lib mos_tt

.temp 27
.control
option sparse
save all
op
write ota-5t_tb-ac.raw
set appendwrite

ac dec 101 1k 100MEG
write ota-5t_tb-ac.raw
plot 20*log10(v_out)

meas ac dcgain MAX vmag(v_out) FROM=10 TO=10k
let f3db = dcgain/sqrt(2)
meas ac fbw WHEN vmag(v_out)=f3db FALL=1
let gainerror=(dcgain-1)/1
print dcgain
print fbw
print gainerror

noise v(v_out) Vin dec 101 1k 100MEG
print onoise_total

.endc

 .include /foss/designs/MCD/analog-circuit-design/xschem/ota-5t_tb-ac.save

**** end user architecture code
**.ends

* expanding   symbol:  ota-5t.sym # of pins=7
** sym_path: /foss/designs/MCD/analog-circuit-design/xschem/ota-5t.sym
** sch_path: /foss/designs/MCD/analog-circuit-design/xschem/ota-5t.sch
.subckt ota-5t vdd vout vinp vinn ibias_20u d_ena vss
*.ipin ibias_20u
*.iopin vdd
*.iopin vss
*.ipin vinp
*.ipin vinn
*.opin vout
*.ipin d_ena
XM5 tail gate_n vss vss sg13_lv_nmos w=0.5u l=5u ng=1
XM4 vout gate_p vdd vdd sg13_lv_pmos w=1.5u l=5u ng=1
XM1 gate_p vinp tail vss sg13_lv_nmos w=2u l=5u ng=1
XM2 vout vinn tail vss sg13_lv_nmos w=2u l=5u ng=1
XM3 gate_p gate_p vdd vdd sg13_lv_pmos w=1.5u l=5u ng=1
XM6 ibias_20u gate_n vss vss sg13_lv_nmos w=2.5u l=5u ng=5
XM9 gate_n ena_n vss vss sg13_lv_nmos w=0.5u l=0.13u ng=1
XM11 gate_p ena vdd vdd sg13_lv_pmos w=1.5u l=0.13u ng=1
XM7 ena ena_n vss vss sg13_lv_nmos w=0.5u l=0.13u ng=1
XM8 ena ena_n vdd vdd sg13_lv_pmos w=1.5u l=0.13u ng=1
XM10 ibias_20u ena gate_n vss sg13_lv_nmos w=0.5u l=0.13u ng=1
XM12 ena_n d_ena vss vss sg13_lv_nmos w=0.5u l=0.13u ng=1
XM13 ena_n d_ena vdd vdd sg13_lv_pmos w=1.5u l=0.13u ng=1
.ends

.GLOBAL GND
.end
