** sch_path: /foss/designs/MCD_VS/Testbench/5t-ota_tb-sk-lpf.sch
**.subckt 5t-ota_tb-sk-lpf
I0 v_dd net1 20u
Vdd v_dd GND 1.5
Vss v_ss GND 0
Venable net2 v_ss 1.5
v_in_p v_in 0 dc 0.8 ac 1
x1 v_dd v_out net4 v_out net1 net2 v_ss ota-5t-custom
R1 v_in net3 2.25MEG
R2 net3 net4 2.25MEG
C2 net4 GND 5p
C1 net3 v_out 10p
C_out v_out GND 50f
**** begin user architecture code

.temp 27
.control
option sparse
save all

* Sweep from 100 Hz to 1 MHz
ac dec 101 100 30MEG

* Plot the response to see your beautiful 20kHz cutoff!
plot v(v_out)
plot 20*log10(v(v_out))

* Calculate the exact -3dB cutoff frequency
meas ac dcgain MAX vmag(v_out) FROM=100 TO=1k
let f3db_target = dcgain / sqrt(2)
meas ac fbw WHEN vmag(v_out)=f3db_target FALL=1

print dcgain
print fbw
.endc

 .lib cornerMOSlv.lib mos_tt

**** end user architecture code
**.ends

* expanding   symbol:  ota-5t-custom.sym # of pins=7
** sym_path: /foss/designs/MCD_VS/Testbench/ota-5t-custom.sym
** sch_path: /foss/designs/MCD_VS/Testbench/ota-5t-custom.sch
.subckt ota-5t-custom vdd vout vinp vinn ibias_20u d_ena vss
*.ipin ibias_20u
*.iopin vdd
*.iopin vss
*.ipin vinp
*.ipin vinn
*.opin vout
*.ipin d_ena
XM5 tail gate_n vss vss sg13_lv_nmos w=1u l=5u ng=1
XM4 vout gate_p vdd vdd sg13_lv_pmos w=2.5u l=5u ng=1
XM1 gate_p vinp tail vss sg13_lv_nmos w=1.5u l=5u ng=1
XM2 vout vinn tail vss sg13_lv_nmos w=1.5u l=5u ng=1
XM3 gate_p gate_p vdd vdd sg13_lv_pmos w=2.5u l=5u ng=1
XM6 ibias_20u gate_n vss vss sg13_lv_nmos w=5u l=5u ng=5
XM9 gate_n ena_n vss vss sg13_lv_nmos w=0.5u l=0.13u ng=1
XM11 gate_p ena vdd vdd sg13_lv_pmos w=1.5u l=0.13u ng=1
XM7 ena ena_n vss vss sg13_lv_nmos w=0.5u l=0.13u ng=1
XM8 ena ena_n vdd vdd sg13_lv_pmos w=1.5u l=0.13u ng=1
XM10 ibias_20u ena gate_n vss sg13_lv_nmos w=0.5u l=0.13u ng=1
XM12 ena_n d_ena vss vss sg13_lv_nmos w=0.5u l=0.13u ng=1
XM13 ena_n d_ena vdd vdd sg13_lv_pmos w=1.5u l=0.13u ng=1
.ends

.GLOBAL GND
.end
