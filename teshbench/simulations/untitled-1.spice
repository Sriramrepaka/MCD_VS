** sch_path: /foss/designs/MCD_VS/Testbench/untitled-1.sch
**.subckt untitled-1 vdd vdd vdd vss vss vdd
*.iopin vdd
*.iopin vdd
*.iopin vdd
*.iopin vss
*.iopin vss
*.iopin vdd
I0 vdd net1 20u
Vdd vdd GND 1.5
Vss vss GND 0
v_in_p v_in GND dc 0.8 ac 1
R1 v_out net2 22.5MEG
R2 GND net3 45MMEG
C1 net2 v_in 5p
C2 net3 net2 5p
x1 vdd v_out net3 v_out net1 vdd vss ota-5t
V1 net3 GND dc 0.8
**** begin user architecture code

.temp 27
.control
option sparse
save all

* Sweep from 100 Hz to 0.5 MHz
ac dec 101 100 0.5MEG

* Plot the response to see your beautiful 10kHz cutoff!
plot v(v_out)
plot 20*log10(v(v_out))

* Calculate the exact -3dB cutoff frequency
meas ac dcgain MAX vmag(v_out) FROM=50k TO=0.5MEG
let f3db_target = dcgain / sqrt(2)
meas ac fbw WHEN vmag(v_out)=f3db_target RISE=1

print dcgain
print fbw
.endc

 .lib cornerMOSlv.lib mos_tt
.lib cornerCAP.lib cap_typ
.lib cornerRES.lib res_typ

**** end user architecture code
**.ends

* expanding   symbol:  ota-5t.sym # of pins=7
** sym_path: /foss/designs/MCD/analog-circuit-design/xschem/ota-5t.sym
** sch_path: /foss/designs/MCD/analog-circuit-design/xschem/ota-5t.sch
.subckt ota-5t vdd vout vinp vinn ibias_20u d_ena vss
*.ipin ibias_20u
*.iopin vdd
*.iopin vss
*.ipin vinp
*.ipin vinn
*.opin vout
*.ipin d_ena
XM5 tail gate_n vss vss sg13_lv_nmos w=1u l=5u ng=1
XM4 vout gate_p vdd vdd sg13_lv_pmos w=2.5u l=5u ng=1
XM1 gate_p vinp tail vss sg13_lv_nmos w=2u l=5u ng=1
XM2 vout vinn tail vss sg13_lv_nmos w=2u l=5u ng=1
XM3 gate_p gate_p vdd vdd sg13_lv_pmos w=2.5u l=5u ng=1
XM6 ibias_20u gate_n vss vss sg13_lv_nmos w=5u l=5u ng=5
XM9 gate_n ena_n vss vss sg13_lv_nmos w=0.5u l=0.13u ng=1
XM11 gate_p ena vdd vdd sg13_lv_pmos w=1.5u l=0.13u ng=1
XM7 ena ena_n vss vss sg13_lv_nmos w=0.5u l=0.13u ng=1
XM8 ena ena_n vdd vdd sg13_lv_pmos w=1.5u l=0.13u ng=1
XM10 ibias_20u ena gate_n vss sg13_lv_nmos w=0.5u l=0.13u ng=1
XM12 ena_n d_ena vss vss sg13_lv_nmos w=0.5u l=0.13u ng=1
XM13 ena_n d_ena vdd vdd sg13_lv_pmos w=1.5u l=0.13u ng=1
.ends

.GLOBAL GND
.end
