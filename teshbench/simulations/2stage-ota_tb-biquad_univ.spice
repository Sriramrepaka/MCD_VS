** sch_path: /foss/designs/MCD_VS/Testbench/2stage-ota_tb-biquad_univ.sch
**.subckt 2stage-ota_tb-biquad_univ HPF BSF LPF BPF vss vdd vdd vss vdd vss vss vdd vdd bias bias bias bias bias vss vdd vdd vdd
*+ vdd
*.opin HPF
*.opin BSF
*.opin LPF
*.opin BPF
*.iopin vss
*.iopin vdd
*.iopin vdd
*.iopin vss
*.iopin vdd
*.iopin vss
*.iopin vss
*.iopin vdd
*.iopin vdd
*.iopin bias
*.iopin bias
*.iopin bias
*.iopin bias
*.iopin bias
*.iopin vss
*.iopin vdd
*.iopin vdd
*.iopin vdd
*.iopin vdd
C1 LPF net2 {C}
C2 BPF net3 {C}
R1 BPF net2 {R}
R2 LPF net4 {R}
R3 net4 HPF {R}
R4 BSF net4 {R}
R5 HPF net3 {R}
R6 BPF net1 {RQ}
R7 net5 net1 {RH}
R8 net1 BSF {R}
V1 net5 GND dc 0.8 ac 1
x1 vdd net9 net3 BPF bias vss ota-2stage
Vdd vdd GND 1.5
Vss vss GND 0
x2 vdd net6 net2 LPF bias vss ota-2stage
x3 vdd net7 net4 HPF bias vss ota-2stage
x4 vdd net8 net1 BSF bias vss ota-2stage
Vdd1 bias GND dc 0.8
I1 vdd net9 20u
I2 vdd net6 20u
I3 vdd net7 20u
I4 vdd net8 20u
**** begin user architecture code

.temp 27
.param R=3.18MEG C=5p RQ=R*0.707 RH=R/1
.control
option sparse
save all
op
write biquad.raw
set appendwrite

ac dec 101 100 1MEG
*ac lin 1000 1 3k
write biquad.raw
plot db(v(LPF)) db(v(HPF)) db(v(BPF)) db(v(BSF))

.endc

 .lib cornerMOSlv.lib mos_tt
.lib cornerCAP.lib cap_typ
.lib cornerRES.lib res_typ

**** end user architecture code
**.ends

* expanding   symbol:  ota-2stage.sym # of pins=6
** sym_path: /foss/designs/MCD_VS/Testbench/ota-2stage.sym
** sch_path: /foss/designs/MCD_VS/Testbench/ota-2stage.sch
.subckt ota-2stage vdd ibias vinn vout vinp vss
*.iopin vdd
*.iopin vss
*.ipin ibias
*.iopin vout
*.ipin vinn
*.ipin vinp
XM1 net1 vinn net3 net3 sg13_lv_nmos w=1u l=2u ng=1
XM2 net2 vinp net3 net3 sg13_lv_nmos w=1u l=2u ng=1
XM4 net2 net1 vdd vdd sg13_lv_pmos w=1u l=2u ng=1
XM3 net1 net1 vdd vdd sg13_lv_pmos w=1u l=2u ng=1
XM5 vout net2 vdd vdd sg13_lv_pmos w=9.5u l=2u ng=1
XM6 ibias ibias vss vss sg13_lv_nmos w=2u l=2u ng=1
XM7 net3 ibias vss vss sg13_lv_nmos w=0.5u l=2u ng=1
XM8 vout ibias vss vss sg13_lv_nmos w=1u l=2u ng=1
XCM vout net4 cap_cmim w=20e-6 l=20e-6
XRN net2 net4 GND rhigh w=1e-6 l=12.6e-6 m=1 b=0
.ends

.GLOBAL GND
.end
